* ==============================================================================
* LepiLED Rev 4.8 — Hysteretic UVLO Testbench (17.48 V ON / 16.66 V OFF)
* Tests 5/9/12/15.75 V PD fallback rejection PLUS slow ramp UP & DOWN through
* realistic 0.30 Ohm source impedance to prove ZERO chatter / motorboating!
* ==============================================================================
.include models.lib
.include al8860.lib

* Realistic source impedance (0.30 Ohm -> ~0.16 V droop under 8-ALL load!)
Vsrc V_SRC 0 PWL(
+ 0     5.0   1.0m  5.0
+ 1.05m 15.75 2.5m  15.75
+ 2.55m 16.20 12.5m 19.20
+ 15.0m 19.20 25.0m 15.80
+ 26.0m 15.80)
Rsrc V_SRC VIN_20V 0.30

* Hysteretic UVLO (U5 TL431 2.500 V + U4A/U4B LM393DR2G + Q2/Q3 2N7002)
R14 VIN_20V V_REF 10.0k
XU5 V_REF 0 TL431_2V5
R24 V_REF V_REF_DAMP 10.0
C16 V_REF_DAMP 0 100n
R15 VIN_20V UVLO_SENSE 30.0k
R16 UVLO_SENSE 0 5.1k
C15 UVLO_SENSE 0 100n
C14 VIN_20V 0 100n
XU4A UVLO_SENSE V_REF UVLO_OK VIN_20V 0 LM393_CH
R17 VIN_20V UVLO_OK 100k
R18 UVLO_OK 0 100k
R19 UVLO_OK UVLO_SENSE 220k
XU4B V_REF UVLO_OK UVLO_FAULT VIN_20V 0 LM393_CH
R20 VIN_20V UVLO_FAULT 56.0k
R21 UVLO_FAULT 0 100k
MQ2 U1_CTRL UVLO_FAULT 0 0 NMOS_2N7002
MQ3 U2_CTRL UVLO_FAULT 0 0 NMOS_2N7002

* Fast-settling 0.5 nF CTRL caps for sweep (8-ALL mode: SW1 open)
C2 VIN_20V 0 1.0u
C3 VIN_20V 0 1.0u
C11 VIN_20V 0 1.0u
R7 VIN_20V VBUS_DAMP 1.0
C10 VBUS_DAMP 0 4.7u
R3 VIN_20V UV_POS 0.30
C6 U1_CTRL 0 0.5n
XU1 SW1_NODE 0 U1_CTRL UV_POS VIN_20V AL8860_WT
D9 SW1_NODE VIN_20V D_SS34
L1 UV_NEG_L SW1_NODE 68u
RL1 UV_NEG UV_NEG_L 0.29
C4 UV_POS UV_C4_DAMP 100n
R22 UV_C4_DAMP UV_NEG 10.0
V_iuv UV_POS UV_A1 0
D1 UV_A1 UV_N1 D_SST10_UV
D2 UV_N1 UV_N2 D_SST10_UV
D3 UV_N2 UV_N3 D_SST10_UV
D4 UV_N3 UV_NEG D_SST10_UV

R4 VIN_20V VIS_POS 0.30
C7 U2_CTRL 0 0.5n
XU2 SW2_NODE 0 U2_CTRL VIS_POS VIN_20V AL8860_WT
D10 SW2_NODE VIN_20V D_SS34
L2 VIS_NEG_L SW2_NODE 68u
RL2 VIS_NEG VIS_NEG_L 0.29
C5 VIS_POS VIS_C5_DAMP 100n
R23 VIS_C5_DAMP VIS_NEG 10.0
V_ivis VIS_POS VIS_A1 0
D5 VIS_A1 VIS_N1 D_XPE2_RB
D7 VIS_N1 VIS_N2 D_XPE2_GRN
D6 VIS_N2 VIS_N3 D_XPE2_RB
D8 VIS_N3 VIS_NEG D_XPE2_CW

.options method=gear reltol=5e-3 abstol=1e-8 vntol=1e-4
.tran 10u 26.0m 0 4u uic

.control
set filetype=ascii
run
meas tran vref_check   AVG v(v_ref)   FROM=13.0m TO=14.8m
meas tran vctrl_5v     AVG v(u1_ctrl) FROM=0.4m TO=0.95m
meas tran vctrl_1575v  AVG v(u1_ctrl) FROM=1.8m TO=2.45m
meas tran i_uv_1575v   AVG i(v_iuv)   FROM=1.8m TO=2.45m
meas tran i_vis_1575v  AVG i(v_ivis)  FROM=1.8m TO=2.45m
meas tran i_uv_19v     AVG i(v_iuv)   FROM=13.5m TO=14.8m
meas tran i_vis_19v    AVG i(v_ivis)  FROM=13.5m TO=14.8m
* Exact turn-on and turn-off VIN_20V thresholds via UVLO_OK crossing 5.0 V
meas tran t_uvlo_on    WHEN v(uvlo_ok)=5.0 RISE=1 FROM=2.5m TO=13.0m
meas tran v_uvlo_on    FIND v(vin_20v) AT=t_uvlo_on
meas tran t_uvlo_off   WHEN v(uvlo_ok)=5.0 FALL=1 FROM=15.0m TO=25.5m
meas tran v_uvlo_off   FIND v(vin_20v) AT=t_uvlo_off
* Verify zero chatter: UVLO_OK stays > 7 V throughout post-turn-on window
meas tran v_ok_min_post MIN v(uvlo_ok) FROM=10.5m TO=14.8m
meas tran i_uv_end_off  AVG i(v_iuv)   FROM=25.2m TO=25.9m
linearize v(vin_20v) v(v_ref) v(uvlo_ok) v(u1_ctrl) v(u2_ctrl) i(v_iuv) i(v_ivis)
wrdata ../outputs/uvlo_sweep_waveforms.txt v(vin_20v) v(v_ref) v(uvlo_ok) v(u1_ctrl) v(u2_ctrl) i(v_iuv) i(v_ivis)
quit
.endc
.end
