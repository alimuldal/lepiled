* ==============================================================================
* LepiLED Rev 4.1 — Fault 2: Shorted LED String (Ch1 UV_POS shorted to UV_NEG at t=2.5 ms)
* ==============================================================================
.include models.lib
.include al8860.lib

Vin VIN_20V 0 20.0

R3 VIN_20V UV_POS 0.30
C6 U1_CTRL 0 0.5n
XU1 SW1_NODE 0 U1_CTRL UV_POS VIN_20V AL8860_WT
D9 SW1_NODE VIN_20V D_B340A
L1 UV_NEG_L SW1_NODE 68u
RL1 UV_NEG UV_NEG_L 0.29
C4 UV_POS UV_C4_DAMP 100n
R22 UV_C4_DAMP UV_NEG 6.8
V_iuv UV_POS UV_A1 0
D1 UV_A1 UV_N1 D_SST10_UV
D2 UV_N1 UV_N2 D_SST10_UV
D3 UV_N2 UV_N3 D_SST10_UV
D4 UV_N3 UV_NEG D_SST10_UV

V_sh n_sh 0 PULSE(0 1 2.5m 1u 1u 20m 50m)
S_sh UV_POS UV_NEG n_sh 0 SW_SH
.model SW_SH SW(VT=0.5 VH=0.05 RON=0.10 ROFF=100Meg)

.options method=gear reltol=5e-3 abstol=1e-8 vntol=1e-4
.tran 5u 5.0m 0 1u uic

.control
set filetype=ascii
run
meas tran il1_avg_pre   AVG i(l1) FROM=1.5m TO=2.4m
meas tran il1_avg_short AVG i(l1) FROM=3.5m TO=4.9m
meas tran il1_pk_short  MAX i(l1) FROM=2.5m TO=4.9m
meas tran vsw1_pk_short MAX v(sw1_node) FROM=2.5m TO=4.9m
linearize v(sw1_node) i(l1) i(v_iuv) v(uv_pos) v(uv_neg)
wrdata ../outputs/fault_short_led.txt v(sw1_node) i(l1) i(v_iuv) v(uv_pos) v(uv_neg)
quit
.endc
.end
