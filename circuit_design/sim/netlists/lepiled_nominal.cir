* LepiLED DIY Maxi Switch - Full Dual-Channel Transient SPICE Simulation
* Sequence: OFF (0..0.2ms) -> 4-UV (0.2..3.5ms? wait: 4-UV 0.2..1.5ms -> 8-ALL 1.5..3.5ms -> 4-UV 3.5..9.5ms)
* Verifies: switching ripple, Ch2 1ms stagger, steady-state LED currents, zero backfeed, complete U2 turn-off (DIM2 < 0.4V, I_VIS < 1uA)

.INCLUDE circuit_design/sim/netlists/models.lib
.INCLUDE circuit_design/sim/netlists/lm3410xmy.lib

* --- 5V USB Power Supply + Realistic 18 AWG <= 1.0 m Round-Trip Cable (0.042 Ohm) & J1 Contact Resistance ---
V_USB VUSB_SRC 0 DC 5.0
R_CABLE VUSB_SRC VBUS 0.042
L_CABLE VBUS VBUS_IN 0.5u
R_J1 VBUS_IN VBUS_PCB 0.040

* USB-C CC1 / CC2 5.1k Rd Pulldowns & ESD Bypass Cap (C12)
R1 CC1 0 5.1k
R2 CC2 0 5.1k
C12 VBUS_PCB 0 100n IC=5.0

* --- Input Protection: F1 (MF-LSMF500/16X), Back-to-Back Q1A/Q1B (DMG2305UX), U3 (TL431), Q2/Q3/Q4, D15/D16, D11 downstream ---
R_F1 VBUS_PCB VBUS_FUSED 0.015
M_Q1A VBUS_FUSED Q1_GATE V_MID V_MID M_DMG2305UX
M_Q1B VIN_PROT   Q1_GATE V_MID V_MID M_DMG2305UX
D11 0 VIN_PROT D_SMBJ5
D15 Q1_GATE V_MID D_Z5V6

* Gate Pull-Up, Soft-Start Sink (warm pre-charged steady state; cold IC=0 tested in lepiled_fault_input_prot.cir) & TL431 OVP Sense
R10 V_MID Q1_GATE 10k
Q3 Q1_GATE Q3_BASE Q3_EMIT Q_MMBT3904
R11 Q3_EMIT 0 1.5k
R14 V_MID Q3_BASE 220k
C11 Q3_BASE 0 100n IC=1.20
R12 V_MID OVP_SENSE 13.7k
R13 OVP_SENSE 0 10.0k
X_U3 OVP_K OVP_SENSE 0 TL431_AI VREF=2.495 IREF_BIAS=2u
R15 V_MID Q2_BASE 10k
R16 Q2_BASE OVP_K 5.6k
Q2 OVP_DRV Q2_BASE V_MID Q_MMBT3906
R17 OVP_DRV Q4_BASE 10k
R20 Q4_BASE 0 100k
Q4 Q3_BASE Q4_BASE 0 Q_MMBT3904
D16A OVP_DRV OVP_DRV_GATE D_BAV70
R18 OVP_DRV_GATE Q1_GATE 220
D16B OVP_DRV OVP_HYS D_BAV70
R19 OVP_HYS OVP_SENSE 68k

* --- Input Bulk & Decoupling MLCCs (Effective Capacitance at 5V DC bias) ---
C1 VIN_PROT C1_ESR 8.0u IC=4.9
R_ESR_C1 C1_ESR 0 0.005
C2 VIN_PROT C2_ESR 8.0u IC=4.9
R_ESR_C2 C2_ESR 0 0.005
C3 VIN_PROT C3_ESR 8.0u IC=4.9
R_ESR_C3 C3_ESR 0 0.005
C7 VIN_PROT 0 100n IC=4.9
C8 VIN_PROT 0 100n IC=4.9

* --- Maxi-Switch SW1 (SPDT On-Off-On) via J4 + D12 (BAV70 Common Cathode) + R5..R7, C6 ---
* Mode schedule:
*   0.0 - 0.2 ms: OFF (both open)
*   0.2 - 1.5 ms: 4-UV (SW_UV_EN = VIN_PROT)
*   1.5 - 3.5 ms: 8-ALL (EN2_NET = VIN_PROT, SW_UV_EN open)
*   3.5 - 9.5 ms: 4-UV (SW_UV_EN = VIN_PROT, EN2_NET open; verifies full 2.0ms RC discharge of DIM2_NET < 0.4V)
V_CTL_UV  CTL_UV  0 PWL(0 0 0.195m 0 0.200m 5 1.495m 5 1.500m 0 3.495m 0 3.500m 5 9.5m 5)
V_CTL_ALL CTL_ALL 0 PWL(0 0 1.495m 0 1.500m 5 3.495m 5 3.500m 0 9.5m 0)
S_SW1_UV  VIN_PROT SW_UV_EN CTL_UV  0 S_TOGGLE
S_SW1_ALL VIN_PROT EN2_NET  CTL_ALL 0 S_TOGGLE
.MODEL S_TOGGLE SW(RON=0.05 ROFF=100Meg VT=2.5 VH=0.1)

* D12 Common-Cathode Diode-OR: Anodes SW_UV_EN & EN2_NET -> Cathode EN1_NET
D12A SW_UV_EN EN1_NET D_BAV70
D12B EN2_NET  EN1_NET D_BAV70

* DIM Pulldowns & Ch2 Stagger RC (R7=10k, C6=100n -> tau_chg=1.0ms, tau_dis=2.0ms via R7+R6)
R5 EN1_NET 0 10k
R6 EN2_NET 0 10k
R7 EN2_NET DIM2_NET 10k
C6 DIM2_NET 0 100n IC=0

* --- Channel 1: 4S Luminus SST-10-UV (U1, L1, D9, C4, C9, R3, D13, R8, D1..D4) ---
L1 VIN_PROT SW1_L 10u
R_DCR_L1 SW1_L SW1_NODE 0.049
X_U1 VIN_PROT SW1_NODE FB1_NET EN1_NET 0 LM3410XMY VFB=0.190 FSW=1.6e6 ICL=2.8 RDS=0.170 DMAX=0.92
D9 SW1_NODE VOUT1 D_B340A
C4 VOUT1 C4_ESR 7.5u IC=4.7
R_ESR_C4 C4_ESR 0 0.005
C9 VOUT1 0 100n IC=4.7
R3 UV_RET 0 0.56
D13 FB1_NET VOUT1 D_Z18V
R8 FB1_NET UV_RET 100

* 4S UV LED String (D1..D4)
D1 VOUT1 UV_N1 D_SST10UV
D2 UV_N1 UV_N2 D_SST10UV
D3 UV_N2 UV_N3 D_SST10UV
D4 UV_N3 UV_SENS1 D_SST10UV
V_SENS_UV UV_SENS1 UV_RET DC 0

* --- Channel 2: 4S Cree XP-E2 (U2, L2, D10, C5, C10, R4, D14, R9, D5..D8) ---
L2 VIN_PROT SW2_L 10u
R_DCR_L2 SW2_L SW2_NODE 0.049
X_U2 VIN_PROT SW2_NODE FB2_NET DIM2_NET 0 LM3410XMY VFB=0.190 FSW=1.6e6 ICL=2.8 RDS=0.170 DMAX=0.92
D10 SW2_NODE VOUT2 D_B340A
C5 VOUT2 C5_ESR 7.5u IC=4.7
R_ESR_C5 C5_ESR 0 0.005
C10 VOUT2 0 100n IC=4.7
R4 VIS_RET 0 0.56
D14 FB2_NET VOUT2 D_Z18V
R9 FB2_NET VIS_RET 100

* 4S Visible LED String (D5,D6 Blue; D7 Green; D8 Cool White)
D5 VOUT2 VIS_N1 D_XPE2_RB
D6 VIS_N1 VIS_N2 D_XPE2_RB
D7 VIS_N2 VIS_N3 D_XPE2_GR
D8 VIS_N3 VIS_SENS2 D_XPE2_CW
V_SENS_VIS VIS_SENS2 VIS_RET DC 0

* --- Simulation Control (9.5 ms warm-started steady state) ---
.IC V(VBUS_PCB)=5.0 V(VBUS_FUSED)=5.0 V(V_MID)=5.0 V(Q2_BASE)=5.0 V(OVP_K)=5.0 V(OVP_SENSE)=2.11 V(OVP_DRV)=0 V(Q4_BASE)=0 V(Q1_GATE)=0.7
.TRAN 40n 9.5m 0 40n UIC

.CONTROL
run
let iin = -i(v_usb)
* Steady-state metrics in initial 4-UV (1.1-1.45ms) and 8-ALL (3.1-3.45ms)
meas tran i_uv_4uv avg i(v_sens_uv) from=1.10m to=1.45m
meas tran i_vis_backfeed max i(v_sens_vis) from=1.10m to=1.45m
meas tran vout1_4uv avg v(vout1) from=1.10m to=1.45m
meas tran vout2_4uv avg v(vout2) from=1.10m to=1.45m
meas tran iin_4uv avg iin from=1.10m to=1.45m

meas tran i_uv_8all avg i(v_sens_uv) from=3.10m to=3.45m
meas tran i_vis_8all avg i(v_sens_vis) from=3.10m to=3.45m
meas tran vout1_8all avg v(vout1) from=3.10m to=3.45m
meas tran vout2_8all avg v(vout2) from=3.10m to=3.45m
meas tran vout1_pp pp v(vout1) from=3.10m to=3.45m
meas tran vout2_pp pp v(vout2) from=3.10m to=3.45m
meas tran il1_max max i(l1) from=0.2m to=9.5m
meas tran il2_max max i(l2) from=1.5m to=9.5m
meas tran iin_8all avg iin from=3.10m to=3.45m
meas tran iin_peak max iin from=0.2m to=9.5m
meas tran vin_prot_min min v(vin_prot) from=0.2m to=9.5m
meas tran dim2_cross when v(dim2_net)=1.8 rise=1

* Verify complete U2 turn-off after 8-ALL -> 4-UV transition at 3.5 ms (check at 9.0-9.5 ms)
meas tran dim2_end avg v(dim2_net) from=9.00m to=9.50m
meas tran il2_end_avg avg i(l2) from=9.00m to=9.50m
meas tran i_vis_end min i(v_sens_vis) from=9.00m to=9.50m
meas tran i_uv_end avg i(v_sens_uv) from=9.00m to=9.50m

set wr_vecnames
set wr_singlescale
wrdata circuit_design/sim/outputs/ngspice_nominal_trace.txt v(vin_prot) v(en1_net) v(dim2_net) v(vout1) v(vout2) v(fb1_net) v(fb2_net) i(l1) i(l2) i(v_sens_uv) i(v_sens_vis) i(v_usb)
quit 0
.ENDC
.END
