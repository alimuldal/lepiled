* ==============================================================================
* LepiLED Rev 4.0 — Fault 1: Open-Circuit LED String (Ch1 J2 Unplugged at t=2.5 ms)
* ==============================================================================
.include models.lib
.include al8860.lib

Vin VIN_20V 0 20.0

R3 VIN_20V UV_POS 0.30
C6 U1_CTRL 0 0.5n
XU1 SW1_NODE 0 U1_CTRL UV_POS VIN_20V AL8860_WT
D9 SW1_NODE VIN_20V D_B340A
L1 UV_NEG_L SW1_NODE 68u
RL1 UV_NEG UV_NEG_L 0.29
C4 UV_POS UV_NEG 1.0u
V_open n_open 0 PULSE(1 0 2.5m 1u 1u 20m 50m)
S_open UV_POS UV_SW n_open 0 SW_BRK
.model SW_BRK SW(VT=0.5 VH=0.05 RON=0.01 ROFF=100Meg)
V_iuv UV_SW UV_A1 0
D1 UV_A1 UV_N1 D_SST10_UV
D2 UV_N1 UV_N2 D_SST10_UV
D3 UV_N2 UV_N3 D_SST10_UV
D4 UV_N3 UV_NEG D_SST10_UV

R4 VIN_20V VIS_POS 0.30
C7 U2_CTRL 0 0.5n
XU2 SW2_NODE 0 U2_CTRL VIS_POS VIN_20V AL8860_WT
D10 SW2_NODE VIN_20V D_B340A
L2 VIS_NEG_L SW2_NODE 68u
RL2 VIS_NEG VIS_NEG_L 0.29
C5 VIS_POS VIS_NEG 1.0u
V_ivis VIS_POS VIS_A1 0
D5 VIS_A1 VIS_N1 D_XPE2_RB
D6 VIS_N1 VIS_N2 D_XPE2_RB
D7 VIS_N2 VIS_N3 D_XPE2_GRN
D8 VIS_N3 VIS_NEG D_XPE2_CW

.options method=gear reltol=5e-3 abstol=1e-8 vntol=1e-4
.tran 5u 5.0m 0 2u uic

.control
set filetype=ascii
run
meas tran vsw1_pk_open  MAX v(sw1_node) FROM=2.5m TO=5.0m
meas tran vuv_pos_open  AVG v(uv_pos)   FROM=3.5m TO=4.9m
meas tran i_uv_open     AVG i(v_iuv)    FROM=3.5m TO=4.9m
meas tran i_l1_open     AVG i(l1)       FROM=3.5m TO=4.9m
meas tran i_vis_during  AVG i(v_ivis)   FROM=3.5m TO=4.9m
linearize v(sw1_node) v(uv_pos) v(uv_neg) i(v_iuv) i(l1) i(v_ivis)
wrdata ../outputs/fault_open_led.txt v(sw1_node) v(uv_pos) v(uv_neg) i(v_iuv) i(l1) i(v_ivis)
quit
.endc
.end
