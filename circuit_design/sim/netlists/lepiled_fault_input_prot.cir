* ==============================================================================
* LepiLED Rev 4.1 — Fault 3: USB-C Input Protection Suite (USB-C Only, S2-A)
*   Case A: Negative -15 V transient on VBUS -> Unidirectional SMBJ22A clamps >= -1.5 V
*   Case B: Inductive USB-C 21 V Hot-Plug (L=0.5 uH, R=0.15 Ohm) -> Overdamped
*           C1+C10/R7 + SMBJ22A keeps V_VBUS_FUSED << 31 V AP33771C / 40 V Q1
*   Case C: Q1 OFF-state bleed (R21=1M) holds VIN_20V near 0 V with PWR_EN=0
* ==============================================================================
.include models.lib

* --- CASE A: Negative -15 V Transient on VBUS (Unidirectional SMBJ22A Clamp) ---
V_neg a_src 0 PULSE(0 -15.0 10u 100n 100n 40u 1m)
Ra_src a_src a_vbus 5.0
RF1_a a_vbus a_vbus_f 0.080
XD11_a 0 a_vbus_f TVS_SMBJ22A
C1_a a_vbus_f 0 1.0u

* --- CASE B: Inductive USB-C 21 V Hot-Plug (L=0.5 uH, R=0.15 Ohm) ---
V_hp b_src 0 PULSE(0 21.0 10u 100n 100n 2m 10m)
Rb_hp b_src b_n1 0.15
Lb_hp b_n1 b_vbus 0.5u
RF1_b b_vbus b_vbus_f 0.080
XD11_b 0 b_vbus_f TVS_SMBJ22A
C1_b b_vbus_f 0 1.0u
R7_b b_vbus_f b_damp 1.0
C10_b b_damp 0 4.7u
R8_b b_vbus_f b_vbus_s 0.005
C11_b b_vbus_s 0 1.0u

* --- CASE C: Q1 OFF-State Leakage & R21 Gate Bleed (VBUS=20 V, PWR_EN=0 V) ---
V_off c_vbus_s 0 20.0
R11_c 0 c_q1_gate 6.2k
C13_c c_q1_gate 0 47n
R21_c c_q1_gate 0 1.0Meg
MQ1_c c_vbus_s c_q1_gate c_vin20 c_vin20 DMN4035L
Rload_c c_vin20 0 100k

.options method=gear reltol=1e-3 abstol=1e-10
.tran 50n 200u 0 50n uic

.control
set filetype=ascii
run
wrdata ../outputs/fault_input_prot.txt v(a_vbus_f) v(b_vbus_f) v(b_vbus_s) v(c_vin20)
meas tran neg_vbus_min   MIN v(a_vbus_f) FROM=0 TO=200u
meas tran hp_vbus_peak   MAX v(b_vbus_f) FROM=0 TO=200u
meas tran hp_vbus_final  AVG v(b_vbus_f) FROM=150u TO=200u
meas tran q1_off_leak_v  MAX v(c_vin20)  FROM=50u TO=200u
quit
.endc
.end
