* LepiLED DIY Maxi Switch - Canonical Top-Level SPICE Netlist (71 RefDes)
* Matches circuit_design/COMPONENT_IDS.csv and circuit_design/schematic.{svg,pdf,png} 1:1
* Note: Run time-domain transient via circuit_design/sim/netlists/lepiled_nominal.cir

.INCLUDE circuit_design/sim/netlists/models.lib
.INCLUDE circuit_design/sim/netlists/lm3410xmy.lib

* --- Subcircuits for Connectors, Switch, Test Pads & Mounting Holes (1:1 RefDes/Net Parity) ---
.SUBCKT USB4085_GFA VBUS CC1 CC2 GND
V_USB_INT VBUS_SRC GND DC 5.0
R_CONTACT VBUS_SRC VBUS 0.04
R_CC1_INS CC1 GND 1G
R_CC2_INS CC2 GND 1G
.ENDS USB4085_GFA

.SUBCKT JST_B2B_XH PIN1 PIN2
R_INS PIN1 PIN2 1G
.ENDS JST_B2B_XH

.SUBCKT JST_B3B_XH PIN1 PIN2 PIN3
R_INS12 PIN1 PIN2 1G
R_INS23 PIN2 PIN3 1G
.ENDS JST_B3B_XH

.SUBCKT SW_100SP3T P1_UV P2_COM P3_ALL P_BUSHING
* Representative static position: 8-ALL (COM->ALL closed 50 mOhm, COM->UV open 100 MOhm)
R_UV_OPEN P1_UV P2_COM 100Meg
R_ALL_ON  P2_COM P3_ALL 0.05
R_BUSH    P_BUSHING 0 1G
.ENDS SW_100SP3T

.SUBCKT BAV70_CC A1 A2 K
D_A A1 K D_BAV70
D_B A2 K D_BAV70
.ENDS BAV70_CC

.SUBCKT BAW56_CA A K1 K2
D_A A K1 D_BAV70
D_B A K2 D_BAV70
.ENDS BAW56_CA

.SUBCKT PAD_1P P_NET
R_PAR P_NET 0 1G
.ENDS PAD_1P

* --- J1: GCT USB4085-GF-A + TP1/TP2 + R1/R2 Rd + C12 ESD ---
X_J1 VBUS CC1 CC2 GND USB4085_GFA
X_TP1 VBUS PAD_1P
X_TP2 GND  PAD_1P
R1 CC1 GND 5.1k
R2 CC2 GND 5.1k
C12 VBUS GND 100n

* --- Input Protection: F1 (MF-LSMF500/16X), Back-to-Back Q1A/Q1B (DMG2305UX-7), U3 (TL431AIDBZR), Q2 (MMBT3906), Q3/Q4 (MMBT3904), D15, D16 (BAW56), D11, R10..R20, C11 ---
R_F1 VBUS VBUS_FUSED 0.015
M_Q1A VBUS_FUSED Q1_GATE V_MID V_MID M_DMG2305UX
M_Q1B VIN_PROT   Q1_GATE V_MID V_MID M_DMG2305UX
D11 GND VIN_PROT D_SMBJ5
D15 Q1_GATE V_MID D_Z5V6

R10 V_MID Q1_GATE 10k
Q_Q3 Q1_GATE Q3_BASE Q3_EMIT Q_MMBT3904
R11 Q3_EMIT GND 1.5k
R14 V_MID Q3_BASE 220k
C11 Q3_BASE GND 100n

R12 V_MID OVP_SENSE 13.7k
R13 OVP_SENSE GND 10.0k
X_U3 OVP_K OVP_SENSE GND TL431_AI VREF=2.495 IREF_BIAS=2u
R15 V_MID Q2_BASE 10k
R16 Q2_BASE OVP_K 5.6k
Q_Q2 OVP_DRV Q2_BASE V_MID Q_MMBT3906
R17 OVP_DRV Q4_BASE 10k
R20 Q4_BASE GND 100k
Q_Q4 Q3_BASE Q4_BASE GND Q_MMBT3904
X_D16 OVP_DRV OVP_DRV_GATE OVP_HYS BAW56_CA
R18 OVP_DRV_GATE Q1_GATE 220
R19 OVP_HYS OVP_SENSE 27k

* --- Input Capacitors (C1..C3 = 10uF 25V X7R; C7..C8 = 100nF) ---
C1 VIN_PROT GND 8.0u
C2 VIN_PROT GND 8.0u
C3 VIN_PROT GND 8.0u
C7 VIN_PROT GND 100n
C8 VIN_PROT GND 100n

* --- Maxi-Switch SW1 + SW1_BOOT via J4 + D12 (BAV70LT1G) + R5..R7, C6 ---
X_J4 SW_UV_EN VIN_PROT EN2_NET JST_B3B_XH
X_SW1 SW_UV_EN VIN_PROT EN2_NET SW1_MECH SW_100SP3T
R_SW1_BOOT SW1_MECH GND 1G
X_D12 SW_UV_EN EN2_NET EN1_NET BAV70_CC
R5 EN1_NET GND 10k
R6 EN2_NET GND 10k
R7 EN2_NET DIM2_NET 10k
C6 DIM2_NET GND 100n

* --- Channel 1: 4S UV-A Boost (U1, L1, D9, C4, C9, R3, D13, R8, J2, D1..D4) ---
L1 VIN_PROT SW1_NODE 10u
X_U1 VIN_PROT SW1_NODE FB1_NET EN1_NET GND LM3410XMY
D9 SW1_NODE VOUT1 D_B340A
C4 VOUT1 GND 7.5u
C9 VOUT1 GND 100n
D13 FB1_NET VOUT1 D_Z18V
R8 FB1_NET UV_RET 100
R3 UV_RET GND 0.56
X_J2 VOUT1 UV_RET JST_B2B_XH
D1 VOUT1 UV_N1 D_SST10UV
D2 UV_N1 UV_N2 D_SST10UV
D3 UV_N2 UV_N3 D_SST10UV
D4 UV_N3 UV_RET D_SST10UV

* --- Channel 2: 4S Visible Boost (U2, L2, D10, C5, C10, R4, D14, R9, J3, D5..D8) ---
L2 VIN_PROT SW2_NODE 10u
X_U2 VIN_PROT SW2_NODE FB2_NET DIM2_NET GND LM3410XMY
D10 SW2_NODE VOUT2 D_B340A
C5 VOUT2 GND 7.5u
C10 VOUT2 GND 100n
D14 FB2_NET VOUT2 D_Z18V
R9 FB2_NET VIS_RET 100
R4 VIS_RET GND 0.56
X_J3 VOUT2 VIS_RET JST_B2B_XH
D5 VOUT2 VIS_N1 D_XPE2_RB
D6 VIS_N1 VIS_N2 D_XPE2_RB
D7 VIS_N2 VIS_N3 D_XPE2_GR
D8 VIS_N3 VIS_RET D_XPE2_CW

* --- Mechanical Mounting Holes H1..H4 tied to GND ---
X_H1 GND PAD_1P
X_H2 GND PAD_1P
X_H3 GND PAD_1P
X_H4 GND PAD_1P

.OP
.END
