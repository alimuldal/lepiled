* LepiLED DIY Maxi Switch — Canonical Top-Level SPICE Netlist (52 RefDes)
* Matches circuit_design/COMPONENT_IDS.csv and circuit_design/schematic.{svg,pdf,png} 1:1
* Run via: /home/alimuldal/.local/share/lepiled-tools/bin/ngspice -b circuit_design/sim/netlists/lepiled_nominal.cir

.INCLUDE circuit_design/sim/netlists/models.lib
.INCLUDE circuit_design/sim/netlists/lm3410xmy.lib

* --- J1: GCT USB4085-GF-A + TP1/TP2 + R1/R2 Rd ---
V_USB VUSB_SRC GND DC 5.0
R_J1 VUSB_SRC VBUS 0.04
* TP1 = VBUS, TP2 = GND
R1 CC1 GND 5.1k
R2 CC2 GND 5.1k

* --- Input Protection: F1 (MF-LSMF300/24X), D11 (SMBJ5.0A), Q1 (DMG2305UX-7), D15, R10 ---
R_F1 VBUS VBUS_FUSED 0.030
D11 GND VBUS_FUSED D_SMBJ5
M_Q1 VBUS_FUSED Q1_GATE VIN_PROT VIN_PROT M_DMG2305UX
D15 Q1_GATE VIN_PROT D_Z5V6
R10 Q1_GATE GND 100k

* --- Input Capacitors (C1..C3 = 10uF 25V X7R; C7..C8 = 100nF) ---
C1 VIN_PROT GND 8.0u
C2 VIN_PROT GND 8.0u
C3 VIN_PROT GND 8.0u
C7 VIN_PROT GND 100n
C8 VIN_PROT GND 100n

* --- Maxi-Switch SW1 (100SP3T1B1M1QEH) via J4 + D12 (BAV70LT1G Common Cathode) + R5..R7, C6 ---
* Example static operating mode: 8-ALL (SW1 connects VIN_PROT -> J4.3 = EN2_NET)
R_SW1_8ALL VIN_PROT EN2_NET 0.05
D12A SW_UV_EN EN1_NET D_BAV70
D12B EN2_NET  EN1_NET D_BAV70
R5 EN1_NET GND 10k
R6 EN2_NET GND 10k
R7 EN2_NET DIM2_NET 10k
C6 DIM2_NET GND 100n

* --- Channel 1: 4S UV-A Boost (U1, L1, D9, C4, C9, R3, D13, R8, J2, D1..D4) ---
L1 VIN_PROT SW1_NODE 10u
X_U1 VIN_PROT SW1_NODE FB1_NET EN1_NET GND LM3410XMY
D9 SW1_NODE VOUT1 D_B340A
C4 VOUT1 GND 7.5u
C9 VOUT1 GND 100n
D13 FB1_NET VOUT1 D_Z20V
R8 FB1_NET UV_RET 100
R3 UV_RET GND 0.56
* Off-board 4S UV LEDs (via J2: VOUT1, UV_RET)
D1 VOUT1 UV_N1 D_SST10UV
D2 UV_N1 UV_N2 D_SST10UV
D3 UV_N2 UV_N3 D_SST10UV
D4 UV_N3 UV_RET D_SST10UV

* --- Channel 2: 4S Visible Boost (U2, L2, D10, C5, C10, R4, D14, R9, J3, D5..D8) ---
L2 VIN_PROT SW2_NODE 10u
X_U2 VIN_PROT SW2_NODE FB2_NET DIM2_NET GND LM3410XMY
D10 SW2_NODE VOUT2 D_B340A
C5 VOUT2 GND 7.5u
C10 VOUT2 GND 100n
D14 FB2_NET VOUT2 D_Z20V
R9 FB2_NET VIS_RET 100
R4 VIS_RET GND 0.56
* Off-board 4S Visible LEDs (via J3: VOUT2, VIS_RET)
D5 VOUT2 VIS_N1 D_XPE2_RB
D6 VIS_N1 VIS_N2 D_XPE2_RB
D7 VIS_N2 VIS_N3 D_XPE2_GR
D8 VIS_N3 VIS_RET D_XPE2_CW

* --- Mechanical Mounting Holes H1..H4 tied to GND ---
R_H1 H1 GND 1m
R_H2 H2 GND 1m
R_H3 H3 GND 1m
R_H4 H4 GND 1m

.END
