* ==============================================================================
* LepiLED DIY Maxi Switch (Rev 4.0 — Option 2: 20 V USB-C PD + Dual AL8860 Buck)
* Canonical Top-Level SPICE Structural Netlist (1:1 Parity with COMPONENT_IDS.csv)
* ==============================================================================
* Topology:
*   Block 1: USB-C PD 3.1 20 V / 1.0 A Sink (J1, F1, D11, C1/C10/R7 damper,
*            R8 5mOhm shunt, U3 AP33771C, Q1A/Q1B back-to-back DMN3404L, R1/R2,
*            R9-R13, C11-C13, D15) + Aux 18-24 V DC Entry (TP1/TP2, F2, D13).
*   Block 2: Hardware 17.25 V UVLO & Ground-Referenced Maxi-Switch
*            (U5 LM4040-2.5, R14, R15/R16/C15 divider, U4 LM393B, C14,
*            R17/D14 5.1 V bias, R5/R6, D12 BAT54, Q2/Q3 BSS138, J4/SW1).
*   Block 3: Ch1 4S UV-A 365 nm Constant-Current Buck Driver (U1 AL8860WT-7,
*            R3 0.30 Ohm -> 333 mA, L1 68 uH, D9 B340A, C2/C8/C4/C6, J2, D1..D4).
*   Block 4: Ch2 4S Visible Constant-Current Buck Driver (U2 AL8860WT-7,
*            R4 0.30 Ohm -> 333 mA, L2 68 uH, D10 B340A, C3/C9/C5/C7, J3, D5..D8).
* ==============================================================================

.include sim/netlists/models.lib
.include sim/netlists/al8860.lib

* --- BLOCK 1: USB-C PD 20V SINK & AUX 18-24V DC INPUT ---
* J1: GCT USB4085-GF-A (pins VBUS, CC1, CC2, 0)
R1 CC1 0 5.1k
R2 CC2 0 5.1k
RF1 VBUS VBUS_FUSED 0.060
* D11: SMBJ22CA bidirectional 22V TVS
XD11 VBUS_FUSED 0 TVS_SMBJ22CA
* Upstream VBUS bulk + overdamped RC damper (total 6.7 uF <= 10 uF USB-C spec)
C1 VBUS_FUSED 0 1.0u
R7 VBUS_FUSED VBUS_DAMP 1.0
C10 VBUS_DAMP 0 4.7u
* U3 AP33771C 5 mOhm current sense & decoupling
R8 VBUS_FUSED VBUS_SENSE 0.005
C11 VBUS_SENSE 0 1.0u
C12 U3_V5V 0 1.0u
R9 U3_VSEL 0 39.0k
R10 U3_ISEL 0 82.0k
R12 VIN_20V U3_VOUT 200
R13 U3_LED PD_LED_A 1.0k
D15 PD_LED_A 0 D_LED_GRN_IND
* Q1A / Q1B common-source back-to-back DMN3404L-7 load switch
R11 U3_PWR_EN Q1_GATE 6.2k
C13 Q1_GATE Q1_MID 47n
MQ1A VBUS_SENSE Q1_GATE Q1_MID Q1_MID DMN3404L
MQ1B VIN_20V Q1_GATE Q1_MID Q1_MID DMN3404L
* Auxiliary 18-24 V DC Entry (TP1/TP2 -> F2 -> D13 -> VIN_20V)
RF2 AUX_IN AUX_FUSED 0.060
D13 AUX_FUSED VIN_20V D_B340A

* --- BLOCK 2: 17.25 V HARDWARE UVLO & GROUND-REFERENCED MAXI-SWITCH ---
R14 VIN_20V V_REF 10.0k
XU5 V_REF 0 LM4040_2V5
R15 VIN_20V UVLO_SENSE 59.0k
R16 UVLO_SENSE 0 10.0k
C15 UVLO_SENSE 0 100n
C14 VIN_20V 0 100n
XU4A UVLO_SENSE V_REF U1_CTRL VIN_20V 0 LM393B_CH
XU4B UVLO_SENSE V_REF U2_CTRL VIN_20V 0 LM393B_CH

* Ground-referenced switch bias (D14 = 5.1 V Zener, J4 = 1:SW_UV_N, 2:GND, 3:SW_ALL_N)
R17 VIN_20V V_SW_BIAS 22.0k
D14 0 V_SW_BIAS D_BZT52C5V1
R5 V_SW_BIAS SW_UV_N 100k
R6 V_SW_BIAS SW_ALL_N 100k
D12 SW_UV_N SW_ALL_N D_BAT54
MQ2 U1_CTRL SW_UV_N 0 0 BSS138_MOD
MQ3 U2_CTRL SW_ALL_N 0 0 BSS138_MOD

* --- BLOCK 3: CHANNEL 1 — 4S UV-A 365 nm BUCK DRIVER (333 mA) ---
C2 VIN_20V 0 10u
C8 VIN_20V 0 100n
R3 VIN_20V UV_POS 0.30
C6 U1_CTRL 0 1.0n
XU1 SW1_NODE 0 U1_CTRL UV_POS VIN_20V AL8860_WT
D9 SW1_NODE VIN_20V D_B340A
L1 UV_NEG SW1_NODE 68u
RL1_DCR UV_NEG UV_NEG_INT 0.29
C4 UV_POS UV_NEG_INT 1.0u
* Off-board via J2 (1: UV_POS, 2: UV_NEG)
D1 UV_POS UV_N1 D_SST10_UV
D2 UV_N1 UV_N2 D_SST10_UV
D3 UV_N2 UV_N3 D_SST10_UV
D4 UV_N3 UV_NEG_INT D_SST10_UV

* --- BLOCK 4: CHANNEL 2 — 4S VISIBLE BUCK DRIVER (333 mA) ---
C3 VIN_20V 0 10u
C9 VIN_20V 0 100n
R4 VIN_20V VIS_POS 0.30
C7 U2_CTRL 0 4.7n
XU2 SW2_NODE 0 U2_CTRL VIS_POS VIN_20V AL8860_WT
D10 SW2_NODE VIN_20V D_B340A
L2 VIS_NEG SW2_NODE 68u
RL2_DCR VIS_NEG VIS_NEG_INT 0.29
C5 VIS_POS VIS_NEG_INT 1.0u
* Off-board via J3 (1: VIS_POS, 2: VIS_NEG)
D5 VIS_POS VIS_N1 D_XPE2_RB
D6 VIS_N1 VIS_N2 D_XPE2_RB
D7 VIS_N2 VIS_N3 D_XPE2_GRN
D8 VIS_N3 VIS_NEG_INT D_XPE2_CW

.end
